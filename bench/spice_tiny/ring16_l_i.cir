tiny coupled ring n=16
I1 0 n0 SIN(0 1m 1e6)
R1 n0 n1 1k
C1 n0 0 1p
RG1 n0 0 10k
R2 n1 n2 1k
C2 n1 0 1p
RG2 n1 0 10k
R3 n2 n3 1k
C3 n2 0 1p
RG3 n2 0 10k
R4 n3 n4 1k
C4 n3 0 1p
RG4 n3 0 10k
R5 n4 n5 1k
C5 n4 0 1p
RG5 n4 0 10k
R6 n5 n6 1k
C6 n5 0 1p
RG6 n5 0 10k
R7 n6 n7 1k
C7 n6 0 1p
RG7 n6 0 10k
R8 n7 n8 1k
C8 n7 0 1p
RG8 n7 0 10k
R9 n8 n9 1k
C9 n8 0 1p
RG9 n8 0 10k
R10 n9 n10 1k
C10 n9 0 1p
RG10 n9 0 10k
R11 n10 n11 1k
C11 n10 0 1p
RG11 n10 0 10k
R12 n11 n12 1k
C12 n11 0 1p
RG12 n11 0 10k
R13 n12 n13 1k
C13 n12 0 1p
RG13 n12 0 10k
R14 n13 n14 1k
C14 n13 0 1p
RG14 n13 0 10k
R15 n14 n15 1k
C15 n14 0 1p
RG15 n14 0 10k
R16 n15 n0 1k
C16 n15 0 1p
RG16 n15 0 10k
.tran 1n 1m
.print tran v(n0)
.end
