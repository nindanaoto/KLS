nano v r diode
V1 a 0 SIN(0 2 1e6)
R1 a b 1k
D1 b 0 dm
C1 b 0 1p
.model dm d(is=1e-14)
.tran 1n 5m
.print tran v(b)
.end
