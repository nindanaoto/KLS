tiny coupled ring n=2
V1 in 0 SIN(0 1 1e6)
R0 in n0 1k
R1 n0 n1 1k
C1 n0 0 1p
RG1 n0 0 10k
D1 n0 0 DM
R2 n1 n0 1k
C2 n1 0 1p
RG2 n1 0 10k
D2 n1 0 DM
.model DM D(IS=1e-14)
.tran 1n 1m
.print tran v(n0)
.end
