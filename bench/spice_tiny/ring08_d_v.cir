tiny coupled ring n=8
V1 in 0 SIN(0 1 1e6)
R0 in n0 1k
R1 n0 n1 1k
C1 n0 0 1p
RG1 n0 0 10k
D1 n0 0 DM
R2 n1 n2 1k
C2 n1 0 1p
RG2 n1 0 10k
D2 n1 0 DM
R3 n2 n3 1k
C3 n2 0 1p
RG3 n2 0 10k
D3 n2 0 DM
R4 n3 n4 1k
C4 n3 0 1p
RG4 n3 0 10k
D4 n3 0 DM
R5 n4 n5 1k
C5 n4 0 1p
RG5 n4 0 10k
D5 n4 0 DM
R6 n5 n6 1k
C6 n5 0 1p
RG6 n5 0 10k
D6 n5 0 DM
R7 n6 n7 1k
C7 n6 0 1p
RG7 n6 0 10k
D7 n6 0 DM
R8 n7 n0 1k
C8 n7 0 1p
RG8 n7 0 10k
D8 n7 0 DM
.model DM D(IS=1e-14)
.tran 1n 1m
.print tran v(n0)
.end
